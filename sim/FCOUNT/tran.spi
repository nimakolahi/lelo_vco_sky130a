*Mixed-signal TB: LELO_VCO + fcount frequency counter
*----------------------------------------------------------------
* The analog VCO drives the digital counter's clock (Vout -> clk).
* Over the gate window T_gate the counter tallies VCO cycles, so
*   result = f_out * T_gate   (a digital code proportional to Vin).
* Run with:  make count     (compiles RTL, then simulates)
*----------------------------------------------------------------
.include ../../work/xsch/LELO_VCO.spice
.lib "$PDK_ROOT/sky130A/libs.tech/ngspice/sky130.lib.spice" tt
.temp 27
.option TNOM=27 GMIN=1e-15 reltol=1e-3 method=gear

.param AVDD=1.8
.param VIN=0.9
.param TSTART=0.5u
.param TGATE=2u

*----------------------------------------------------------------
* Force
*----------------------------------------------------------------
VSS  VSS 0        dc 0
VDD  VDD_1V8 VSS  pwl 0 0 10n {AVDD}
VINP Vin VSS      dc {VIN}

* measurement gate: low, then high for T_gate, then low
VGATE gate 0 pwl 0 0 {TSTART} 0 {TSTART+1n} {AVDD} {TSTART+TGATE} {AVDD} {TSTART+TGATE+1n} 0

*----------------------------------------------------------------
* DUT (analog VCO) + digital counter
*----------------------------------------------------------------
XDUT VDD_1V8 VSS Vin Vout LELO_VCO

* tie the VCO output to the counter clock input (auto analog->digital bridge)
VLINK clk Vout dc 0

.include svinst.spi

.save v(Vout) v(gate) v(dec_count) v(dec_result)

*----------------------------------------------------------------
* NGSPICE control
*----------------------------------------------------------------
.control
  set num_threads=8
  unset askquit

  *- Override the default digital output bridge to 1.8 V levels
  pre_set auto_bridge_d_out =
     + ( ".model auto_dac dac_bridge(out_low = 0.0 out_high = 1.8)"
     +   "auto_bridge%d [ %s ] [ %s ] auto_dac" )

  optran 0 0 0 1n 1u 0
  tran 20p 3u

  let idx = length(v(dec_result)) - 1
  let ncount = v(dec_result)[idx]*1000
  echo "MEASURED_COUNT" $&ncount
  wrdata fcount_wave.dat v(dec_count) v(gate) v(Vout)
  quit
.endc

.end
